* sg13g2_nand2_1 -- generated by design/gen_netlists.py from example_config.json; do not edit.
* family nand2, drive 1, L=130n, supply 1.20 V.
* Y = !(A*B)
.subckt sg13g2_nand2_1 A B Y VDD VSS
XMN0 Y A n1 VSS sg13_lv_nmos w=1000n l=130n ng=1 m=1
XMN1 n1 B VSS VSS sg13_lv_nmos w=1000n l=130n ng=1 m=1
XMP0 Y A VDD VDD sg13_lv_pmos w=800n l=130n ng=1 m=1
XMP1 Y B VDD VDD sg13_lv_pmos w=800n l=130n ng=1 m=1
.ends sg13g2_nand2_1
