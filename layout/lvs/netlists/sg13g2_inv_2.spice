* sg13g2_inv_2 -- generated by design/gen_netlists.py from example_config.json; do not edit.
* family inv, drive 2, L=130n, supply 1.20 V.
* Y = !A
.subckt sg13g2_inv_2 A Y VDD VSS
XMN0 Y A VSS VSS sg13_lv_nmos w=1000n l=130n ng=1 m=1
XMP0 Y A VDD VDD sg13_lv_pmos w=1600n l=130n ng=2 m=1
.ends sg13g2_inv_2
