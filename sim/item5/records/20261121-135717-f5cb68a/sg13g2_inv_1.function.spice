* sg13g2_inv_1 function testbench (sim.item5, spec row 9): logical
* function at the rails -- inputs step through all 2 input
* combinations, output sampled 2 ns into each state.
.include ../../../../layout/lvs/netlists/sg13g2_inv_1.spice
Vdd VDD 0 DC 1.2
Vss VSS 0 DC 0
Vin_A in_A 0 PWL(2e-11 0.0 3e-09 0.0 3.02e-09 1.2 6e-09 1.2)
XDUT in_A y_dut_Y VDD VSS sg13g2_inv_1
