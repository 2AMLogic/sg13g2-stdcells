* sg13g2_nand2_1 timing testbench (sim.item5, spec row 9): delay and
* transition at every (input transition, output load) point of the committed
* view sg13g2_stdcells_tt_1p20v_25c, one DUT instance per (arc, slew, load). Replicates the
* klt characterize stimulus: a linear rail-to-rail ramp whose threshold-to-
* threshold duration equals the tabulated input transition (ramp = slew/0.6).
.include ../../../../layout/lvs/netlists/sg13g2_nand2_1.spice
Vdd VDD 0 DC 1.2
Vss VSS 0 DC 0
VA_s0p02_l0p001 in_A_s0p02_l0p001 0 PWL(0 0 2e-09 0 2.0333333333333333e-09 1.2 4.033333333333333e-09 1.2 4.066666666666667e-09 0 8e-09 0)
XA_s0p02_l0p001 in_A_s0p02_l0p001 VDD y_A_s0p02_l0p001 VDD VSS sg13g2_nand2_1
CA_s0p02_l0p001_cl y_A_s0p02_l0p001 0 1e-15
VA_s0p02_l0p003 in_A_s0p02_l0p003 0 PWL(0 0 2e-09 0 2.0333333333333333e-09 1.2 4.033333333333333e-09 1.2 4.066666666666667e-09 0 8e-09 0)
XA_s0p02_l0p003 in_A_s0p02_l0p003 VDD y_A_s0p02_l0p003 VDD VSS sg13g2_nand2_1
CA_s0p02_l0p003_cl y_A_s0p02_l0p003 0 3e-15
VA_s0p02_l0p01 in_A_s0p02_l0p01 0 PWL(0 0 2e-09 0 2.0333333333333333e-09 1.2 4.033333333333333e-09 1.2 4.066666666666667e-09 0 8e-09 0)
XA_s0p02_l0p01 in_A_s0p02_l0p01 VDD y_A_s0p02_l0p01 VDD VSS sg13g2_nand2_1
CA_s0p02_l0p01_cl y_A_s0p02_l0p01 0 1e-14
VA_s0p02_l0p03 in_A_s0p02_l0p03 0 PWL(0 0 2e-09 0 2.0333333333333333e-09 1.2 4.033333333333333e-09 1.2 4.066666666666667e-09 0 8e-09 0)
XA_s0p02_l0p03 in_A_s0p02_l0p03 VDD y_A_s0p02_l0p03 VDD VSS sg13g2_nand2_1
CA_s0p02_l0p03_cl y_A_s0p02_l0p03 0 3e-14
VA_s0p02_l0p1 in_A_s0p02_l0p1 0 PWL(0 0 2e-09 0 2.0333333333333333e-09 1.2 4.033333333333333e-09 1.2 4.066666666666667e-09 0 8e-09 0)
XA_s0p02_l0p1 in_A_s0p02_l0p1 VDD y_A_s0p02_l0p1 VDD VSS sg13g2_nand2_1
CA_s0p02_l0p1_cl y_A_s0p02_l0p1 0 1e-13
VA_s0p05_l0p001 in_A_s0p05_l0p001 0 PWL(0 0 2e-09 0 2.0833333333333334e-09 1.2 4.0833333333333335e-09 1.2 4.166666666666667e-09 0 8e-09 0)
XA_s0p05_l0p001 in_A_s0p05_l0p001 VDD y_A_s0p05_l0p001 VDD VSS sg13g2_nand2_1
CA_s0p05_l0p001_cl y_A_s0p05_l0p001 0 1e-15
VA_s0p05_l0p003 in_A_s0p05_l0p003 0 PWL(0 0 2e-09 0 2.0833333333333334e-09 1.2 4.0833333333333335e-09 1.2 4.166666666666667e-09 0 8e-09 0)
XA_s0p05_l0p003 in_A_s0p05_l0p003 VDD y_A_s0p05_l0p003 VDD VSS sg13g2_nand2_1
CA_s0p05_l0p003_cl y_A_s0p05_l0p003 0 3e-15
VA_s0p05_l0p01 in_A_s0p05_l0p01 0 PWL(0 0 2e-09 0 2.0833333333333334e-09 1.2 4.0833333333333335e-09 1.2 4.166666666666667e-09 0 8e-09 0)
XA_s0p05_l0p01 in_A_s0p05_l0p01 VDD y_A_s0p05_l0p01 VDD VSS sg13g2_nand2_1
CA_s0p05_l0p01_cl y_A_s0p05_l0p01 0 1e-14
VA_s0p05_l0p03 in_A_s0p05_l0p03 0 PWL(0 0 2e-09 0 2.0833333333333334e-09 1.2 4.0833333333333335e-09 1.2 4.166666666666667e-09 0 8e-09 0)
XA_s0p05_l0p03 in_A_s0p05_l0p03 VDD y_A_s0p05_l0p03 VDD VSS sg13g2_nand2_1
CA_s0p05_l0p03_cl y_A_s0p05_l0p03 0 3e-14
VA_s0p05_l0p1 in_A_s0p05_l0p1 0 PWL(0 0 2e-09 0 2.0833333333333334e-09 1.2 4.0833333333333335e-09 1.2 4.166666666666667e-09 0 8e-09 0)
XA_s0p05_l0p1 in_A_s0p05_l0p1 VDD y_A_s0p05_l0p1 VDD VSS sg13g2_nand2_1
CA_s0p05_l0p1_cl y_A_s0p05_l0p1 0 1e-13
VA_s0p1_l0p001 in_A_s0p1_l0p001 0 PWL(0 0 2e-09 0 2.1666666666666666e-09 1.2 4.166666666666667e-09 1.2 4.333333333333333e-09 0 8e-09 0)
XA_s0p1_l0p001 in_A_s0p1_l0p001 VDD y_A_s0p1_l0p001 VDD VSS sg13g2_nand2_1
CA_s0p1_l0p001_cl y_A_s0p1_l0p001 0 1e-15
VA_s0p1_l0p003 in_A_s0p1_l0p003 0 PWL(0 0 2e-09 0 2.1666666666666666e-09 1.2 4.166666666666667e-09 1.2 4.333333333333333e-09 0 8e-09 0)
XA_s0p1_l0p003 in_A_s0p1_l0p003 VDD y_A_s0p1_l0p003 VDD VSS sg13g2_nand2_1
CA_s0p1_l0p003_cl y_A_s0p1_l0p003 0 3e-15
VA_s0p1_l0p01 in_A_s0p1_l0p01 0 PWL(0 0 2e-09 0 2.1666666666666666e-09 1.2 4.166666666666667e-09 1.2 4.333333333333333e-09 0 8e-09 0)
XA_s0p1_l0p01 in_A_s0p1_l0p01 VDD y_A_s0p1_l0p01 VDD VSS sg13g2_nand2_1
CA_s0p1_l0p01_cl y_A_s0p1_l0p01 0 1e-14
VA_s0p1_l0p03 in_A_s0p1_l0p03 0 PWL(0 0 2e-09 0 2.1666666666666666e-09 1.2 4.166666666666667e-09 1.2 4.333333333333333e-09 0 8e-09 0)
XA_s0p1_l0p03 in_A_s0p1_l0p03 VDD y_A_s0p1_l0p03 VDD VSS sg13g2_nand2_1
CA_s0p1_l0p03_cl y_A_s0p1_l0p03 0 3e-14
VA_s0p1_l0p1 in_A_s0p1_l0p1 0 PWL(0 0 2e-09 0 2.1666666666666666e-09 1.2 4.166666666666667e-09 1.2 4.333333333333333e-09 0 8e-09 0)
XA_s0p1_l0p1 in_A_s0p1_l0p1 VDD y_A_s0p1_l0p1 VDD VSS sg13g2_nand2_1
CA_s0p1_l0p1_cl y_A_s0p1_l0p1 0 1e-13
VA_s0p2_l0p001 in_A_s0p2_l0p001 0 PWL(0 0 2e-09 0 2.3333333333333335e-09 1.2 4.333333333333334e-09 1.2 4.666666666666667e-09 0 8e-09 0)
XA_s0p2_l0p001 in_A_s0p2_l0p001 VDD y_A_s0p2_l0p001 VDD VSS sg13g2_nand2_1
CA_s0p2_l0p001_cl y_A_s0p2_l0p001 0 1e-15
VA_s0p2_l0p003 in_A_s0p2_l0p003 0 PWL(0 0 2e-09 0 2.3333333333333335e-09 1.2 4.333333333333334e-09 1.2 4.666666666666667e-09 0 8e-09 0)
XA_s0p2_l0p003 in_A_s0p2_l0p003 VDD y_A_s0p2_l0p003 VDD VSS sg13g2_nand2_1
CA_s0p2_l0p003_cl y_A_s0p2_l0p003 0 3e-15
VA_s0p2_l0p01 in_A_s0p2_l0p01 0 PWL(0 0 2e-09 0 2.3333333333333335e-09 1.2 4.333333333333334e-09 1.2 4.666666666666667e-09 0 8e-09 0)
XA_s0p2_l0p01 in_A_s0p2_l0p01 VDD y_A_s0p2_l0p01 VDD VSS sg13g2_nand2_1
CA_s0p2_l0p01_cl y_A_s0p2_l0p01 0 1e-14
VA_s0p2_l0p03 in_A_s0p2_l0p03 0 PWL(0 0 2e-09 0 2.3333333333333335e-09 1.2 4.333333333333334e-09 1.2 4.666666666666667e-09 0 8e-09 0)
XA_s0p2_l0p03 in_A_s0p2_l0p03 VDD y_A_s0p2_l0p03 VDD VSS sg13g2_nand2_1
CA_s0p2_l0p03_cl y_A_s0p2_l0p03 0 3e-14
VA_s0p2_l0p1 in_A_s0p2_l0p1 0 PWL(0 0 2e-09 0 2.3333333333333335e-09 1.2 4.333333333333334e-09 1.2 4.666666666666667e-09 0 8e-09 0)
XA_s0p2_l0p1 in_A_s0p2_l0p1 VDD y_A_s0p2_l0p1 VDD VSS sg13g2_nand2_1
CA_s0p2_l0p1_cl y_A_s0p2_l0p1 0 1e-13
VA_s0p4_l0p001 in_A_s0p4_l0p001 0 PWL(0 0 2e-09 0 2.6666666666666666e-09 1.2 4.666666666666667e-09 1.2 5.333333333333334e-09 0 8e-09 0)
XA_s0p4_l0p001 in_A_s0p4_l0p001 VDD y_A_s0p4_l0p001 VDD VSS sg13g2_nand2_1
CA_s0p4_l0p001_cl y_A_s0p4_l0p001 0 1e-15
VA_s0p4_l0p003 in_A_s0p4_l0p003 0 PWL(0 0 2e-09 0 2.6666666666666666e-09 1.2 4.666666666666667e-09 1.2 5.333333333333334e-09 0 8e-09 0)
XA_s0p4_l0p003 in_A_s0p4_l0p003 VDD y_A_s0p4_l0p003 VDD VSS sg13g2_nand2_1
CA_s0p4_l0p003_cl y_A_s0p4_l0p003 0 3e-15
VA_s0p4_l0p01 in_A_s0p4_l0p01 0 PWL(0 0 2e-09 0 2.6666666666666666e-09 1.2 4.666666666666667e-09 1.2 5.333333333333334e-09 0 8e-09 0)
XA_s0p4_l0p01 in_A_s0p4_l0p01 VDD y_A_s0p4_l0p01 VDD VSS sg13g2_nand2_1
CA_s0p4_l0p01_cl y_A_s0p4_l0p01 0 1e-14
VA_s0p4_l0p03 in_A_s0p4_l0p03 0 PWL(0 0 2e-09 0 2.6666666666666666e-09 1.2 4.666666666666667e-09 1.2 5.333333333333334e-09 0 8e-09 0)
XA_s0p4_l0p03 in_A_s0p4_l0p03 VDD y_A_s0p4_l0p03 VDD VSS sg13g2_nand2_1
CA_s0p4_l0p03_cl y_A_s0p4_l0p03 0 3e-14
VA_s0p4_l0p1 in_A_s0p4_l0p1 0 PWL(0 0 2e-09 0 2.6666666666666666e-09 1.2 4.666666666666667e-09 1.2 5.333333333333334e-09 0 8e-09 0)
XA_s0p4_l0p1 in_A_s0p4_l0p1 VDD y_A_s0p4_l0p1 VDD VSS sg13g2_nand2_1
CA_s0p4_l0p1_cl y_A_s0p4_l0p1 0 1e-13
VB_s0p02_l0p001 in_B_s0p02_l0p001 0 PWL(0 0 2e-09 0 2.0333333333333333e-09 1.2 4.033333333333333e-09 1.2 4.066666666666667e-09 0 8e-09 0)
XB_s0p02_l0p001 VDD in_B_s0p02_l0p001 y_B_s0p02_l0p001 VDD VSS sg13g2_nand2_1
CB_s0p02_l0p001_cl y_B_s0p02_l0p001 0 1e-15
VB_s0p02_l0p003 in_B_s0p02_l0p003 0 PWL(0 0 2e-09 0 2.0333333333333333e-09 1.2 4.033333333333333e-09 1.2 4.066666666666667e-09 0 8e-09 0)
XB_s0p02_l0p003 VDD in_B_s0p02_l0p003 y_B_s0p02_l0p003 VDD VSS sg13g2_nand2_1
CB_s0p02_l0p003_cl y_B_s0p02_l0p003 0 3e-15
VB_s0p02_l0p01 in_B_s0p02_l0p01 0 PWL(0 0 2e-09 0 2.0333333333333333e-09 1.2 4.033333333333333e-09 1.2 4.066666666666667e-09 0 8e-09 0)
XB_s0p02_l0p01 VDD in_B_s0p02_l0p01 y_B_s0p02_l0p01 VDD VSS sg13g2_nand2_1
CB_s0p02_l0p01_cl y_B_s0p02_l0p01 0 1e-14
VB_s0p02_l0p03 in_B_s0p02_l0p03 0 PWL(0 0 2e-09 0 2.0333333333333333e-09 1.2 4.033333333333333e-09 1.2 4.066666666666667e-09 0 8e-09 0)
XB_s0p02_l0p03 VDD in_B_s0p02_l0p03 y_B_s0p02_l0p03 VDD VSS sg13g2_nand2_1
CB_s0p02_l0p03_cl y_B_s0p02_l0p03 0 3e-14
VB_s0p02_l0p1 in_B_s0p02_l0p1 0 PWL(0 0 2e-09 0 2.0333333333333333e-09 1.2 4.033333333333333e-09 1.2 4.066666666666667e-09 0 8e-09 0)
XB_s0p02_l0p1 VDD in_B_s0p02_l0p1 y_B_s0p02_l0p1 VDD VSS sg13g2_nand2_1
CB_s0p02_l0p1_cl y_B_s0p02_l0p1 0 1e-13
VB_s0p05_l0p001 in_B_s0p05_l0p001 0 PWL(0 0 2e-09 0 2.0833333333333334e-09 1.2 4.0833333333333335e-09 1.2 4.166666666666667e-09 0 8e-09 0)
XB_s0p05_l0p001 VDD in_B_s0p05_l0p001 y_B_s0p05_l0p001 VDD VSS sg13g2_nand2_1
CB_s0p05_l0p001_cl y_B_s0p05_l0p001 0 1e-15
VB_s0p05_l0p003 in_B_s0p05_l0p003 0 PWL(0 0 2e-09 0 2.0833333333333334e-09 1.2 4.0833333333333335e-09 1.2 4.166666666666667e-09 0 8e-09 0)
XB_s0p05_l0p003 VDD in_B_s0p05_l0p003 y_B_s0p05_l0p003 VDD VSS sg13g2_nand2_1
CB_s0p05_l0p003_cl y_B_s0p05_l0p003 0 3e-15
VB_s0p05_l0p01 in_B_s0p05_l0p01 0 PWL(0 0 2e-09 0 2.0833333333333334e-09 1.2 4.0833333333333335e-09 1.2 4.166666666666667e-09 0 8e-09 0)
XB_s0p05_l0p01 VDD in_B_s0p05_l0p01 y_B_s0p05_l0p01 VDD VSS sg13g2_nand2_1
CB_s0p05_l0p01_cl y_B_s0p05_l0p01 0 1e-14
VB_s0p05_l0p03 in_B_s0p05_l0p03 0 PWL(0 0 2e-09 0 2.0833333333333334e-09 1.2 4.0833333333333335e-09 1.2 4.166666666666667e-09 0 8e-09 0)
XB_s0p05_l0p03 VDD in_B_s0p05_l0p03 y_B_s0p05_l0p03 VDD VSS sg13g2_nand2_1
CB_s0p05_l0p03_cl y_B_s0p05_l0p03 0 3e-14
VB_s0p05_l0p1 in_B_s0p05_l0p1 0 PWL(0 0 2e-09 0 2.0833333333333334e-09 1.2 4.0833333333333335e-09 1.2 4.166666666666667e-09 0 8e-09 0)
XB_s0p05_l0p1 VDD in_B_s0p05_l0p1 y_B_s0p05_l0p1 VDD VSS sg13g2_nand2_1
CB_s0p05_l0p1_cl y_B_s0p05_l0p1 0 1e-13
VB_s0p1_l0p001 in_B_s0p1_l0p001 0 PWL(0 0 2e-09 0 2.1666666666666666e-09 1.2 4.166666666666667e-09 1.2 4.333333333333333e-09 0 8e-09 0)
XB_s0p1_l0p001 VDD in_B_s0p1_l0p001 y_B_s0p1_l0p001 VDD VSS sg13g2_nand2_1
CB_s0p1_l0p001_cl y_B_s0p1_l0p001 0 1e-15
VB_s0p1_l0p003 in_B_s0p1_l0p003 0 PWL(0 0 2e-09 0 2.1666666666666666e-09 1.2 4.166666666666667e-09 1.2 4.333333333333333e-09 0 8e-09 0)
XB_s0p1_l0p003 VDD in_B_s0p1_l0p003 y_B_s0p1_l0p003 VDD VSS sg13g2_nand2_1
CB_s0p1_l0p003_cl y_B_s0p1_l0p003 0 3e-15
VB_s0p1_l0p01 in_B_s0p1_l0p01 0 PWL(0 0 2e-09 0 2.1666666666666666e-09 1.2 4.166666666666667e-09 1.2 4.333333333333333e-09 0 8e-09 0)
XB_s0p1_l0p01 VDD in_B_s0p1_l0p01 y_B_s0p1_l0p01 VDD VSS sg13g2_nand2_1
CB_s0p1_l0p01_cl y_B_s0p1_l0p01 0 1e-14
VB_s0p1_l0p03 in_B_s0p1_l0p03 0 PWL(0 0 2e-09 0 2.1666666666666666e-09 1.2 4.166666666666667e-09 1.2 4.333333333333333e-09 0 8e-09 0)
XB_s0p1_l0p03 VDD in_B_s0p1_l0p03 y_B_s0p1_l0p03 VDD VSS sg13g2_nand2_1
CB_s0p1_l0p03_cl y_B_s0p1_l0p03 0 3e-14
VB_s0p1_l0p1 in_B_s0p1_l0p1 0 PWL(0 0 2e-09 0 2.1666666666666666e-09 1.2 4.166666666666667e-09 1.2 4.333333333333333e-09 0 8e-09 0)
XB_s0p1_l0p1 VDD in_B_s0p1_l0p1 y_B_s0p1_l0p1 VDD VSS sg13g2_nand2_1
CB_s0p1_l0p1_cl y_B_s0p1_l0p1 0 1e-13
VB_s0p2_l0p001 in_B_s0p2_l0p001 0 PWL(0 0 2e-09 0 2.3333333333333335e-09 1.2 4.333333333333334e-09 1.2 4.666666666666667e-09 0 8e-09 0)
XB_s0p2_l0p001 VDD in_B_s0p2_l0p001 y_B_s0p2_l0p001 VDD VSS sg13g2_nand2_1
CB_s0p2_l0p001_cl y_B_s0p2_l0p001 0 1e-15
VB_s0p2_l0p003 in_B_s0p2_l0p003 0 PWL(0 0 2e-09 0 2.3333333333333335e-09 1.2 4.333333333333334e-09 1.2 4.666666666666667e-09 0 8e-09 0)
XB_s0p2_l0p003 VDD in_B_s0p2_l0p003 y_B_s0p2_l0p003 VDD VSS sg13g2_nand2_1
CB_s0p2_l0p003_cl y_B_s0p2_l0p003 0 3e-15
VB_s0p2_l0p01 in_B_s0p2_l0p01 0 PWL(0 0 2e-09 0 2.3333333333333335e-09 1.2 4.333333333333334e-09 1.2 4.666666666666667e-09 0 8e-09 0)
XB_s0p2_l0p01 VDD in_B_s0p2_l0p01 y_B_s0p2_l0p01 VDD VSS sg13g2_nand2_1
CB_s0p2_l0p01_cl y_B_s0p2_l0p01 0 1e-14
VB_s0p2_l0p03 in_B_s0p2_l0p03 0 PWL(0 0 2e-09 0 2.3333333333333335e-09 1.2 4.333333333333334e-09 1.2 4.666666666666667e-09 0 8e-09 0)
XB_s0p2_l0p03 VDD in_B_s0p2_l0p03 y_B_s0p2_l0p03 VDD VSS sg13g2_nand2_1
CB_s0p2_l0p03_cl y_B_s0p2_l0p03 0 3e-14
VB_s0p2_l0p1 in_B_s0p2_l0p1 0 PWL(0 0 2e-09 0 2.3333333333333335e-09 1.2 4.333333333333334e-09 1.2 4.666666666666667e-09 0 8e-09 0)
XB_s0p2_l0p1 VDD in_B_s0p2_l0p1 y_B_s0p2_l0p1 VDD VSS sg13g2_nand2_1
CB_s0p2_l0p1_cl y_B_s0p2_l0p1 0 1e-13
VB_s0p4_l0p001 in_B_s0p4_l0p001 0 PWL(0 0 2e-09 0 2.6666666666666666e-09 1.2 4.666666666666667e-09 1.2 5.333333333333334e-09 0 8e-09 0)
XB_s0p4_l0p001 VDD in_B_s0p4_l0p001 y_B_s0p4_l0p001 VDD VSS sg13g2_nand2_1
CB_s0p4_l0p001_cl y_B_s0p4_l0p001 0 1e-15
VB_s0p4_l0p003 in_B_s0p4_l0p003 0 PWL(0 0 2e-09 0 2.6666666666666666e-09 1.2 4.666666666666667e-09 1.2 5.333333333333334e-09 0 8e-09 0)
XB_s0p4_l0p003 VDD in_B_s0p4_l0p003 y_B_s0p4_l0p003 VDD VSS sg13g2_nand2_1
CB_s0p4_l0p003_cl y_B_s0p4_l0p003 0 3e-15
VB_s0p4_l0p01 in_B_s0p4_l0p01 0 PWL(0 0 2e-09 0 2.6666666666666666e-09 1.2 4.666666666666667e-09 1.2 5.333333333333334e-09 0 8e-09 0)
XB_s0p4_l0p01 VDD in_B_s0p4_l0p01 y_B_s0p4_l0p01 VDD VSS sg13g2_nand2_1
CB_s0p4_l0p01_cl y_B_s0p4_l0p01 0 1e-14
VB_s0p4_l0p03 in_B_s0p4_l0p03 0 PWL(0 0 2e-09 0 2.6666666666666666e-09 1.2 4.666666666666667e-09 1.2 5.333333333333334e-09 0 8e-09 0)
XB_s0p4_l0p03 VDD in_B_s0p4_l0p03 y_B_s0p4_l0p03 VDD VSS sg13g2_nand2_1
CB_s0p4_l0p03_cl y_B_s0p4_l0p03 0 3e-14
VB_s0p4_l0p1 in_B_s0p4_l0p1 0 PWL(0 0 2e-09 0 2.6666666666666666e-09 1.2 4.666666666666667e-09 1.2 5.333333333333334e-09 0 8e-09 0)
XB_s0p4_l0p1 VDD in_B_s0p4_l0p1 y_B_s0p4_l0p1 VDD VSS sg13g2_nand2_1
CB_s0p4_l0p1_cl y_B_s0p4_l0p1 0 1e-13
