* extracted by klt extract --deck sg13g2
* parasitic model (--parasitics):
* - capacitance: net-to-ground for every net's own (non-coupled) area/perimeter, plus net-to-net for the vertical-overlap coupling `coupling` describes below -- a coupled net pair gets a direct capacitor between their two hub nodes, not just capacitors to the deck's ground/substrate net
* - coupling: vertical overlap (crossover) unconditionally -- where one net's conductor on an adjacent metal level sits directly over another *distinct* net's conductor, that overlap area is charged between the two nets instead of to ground (issue #760) -- plus lateral (same-layer, sidewall) coupling, but only for a net pair naming one of the caller's declared `--critical-net` nets (issue #976): facing-edge length within that layer's own minimum-spacing lookback is charged between the two nets, *additively* (not deducted from either net's substrate fringe term, unlike the vertical case -- a known simplification). Any same-layer pair with neither side named `--critical-net`, and fringe shielding in general, are still not modelled
* - resistance: single lumped series resistance per net, distributed as a star across that net's device terminals (issue #592) -- not a per-segment, distributed RC ladder, *unless* `--distributed-rc` names this net via `--critical-net` (issue #977, Epic #709 Phase 2b): then the net's terminals are ordered along their approximate physical spread and its total R/C is broken into a chain of per-segment resistors (segment length proportional to inter-terminal distance) with a ground capacitor at each terminal node (proportional to its adjacent segment length/2), instead of one star hub -- still an approximation (terminal position is a device-placement proxy, not true per-segment routing geometry), but a strictly finer-grained one than the single-hub star
* - frequency: quasi-static -- one frequency-independent R and C per net; no skin effect, no distributed transmission-line behavior
* - substrate tie: 1e+12 ohm to ground -- the substrate is capacitively floating in transient analysis (DC reference only); see --substrate-tie-ohms
.GLOBAL vsubs

* cell sg13g2_nand2_1
* pin A
* pin B
* pin VDD
* pin VSS
* pin Y
.SUBCKT sg13g2_nand2_1 A B Y VDD VSS
* device instance $1 r0 *1 0.63,0.9 nfet
X$1 \$2__t0 A__t0 Y__t0 VSS__t0 sg13_lv_nmos L=0.13U W=1U AS=0.295P AD=0.145P
+ PS=2.59U PD=1.29U
* device instance $2 r0 *1 1.05,0.9 nfet
X$2 VSS__t2 B__t0 \$2__t1 VSS__t1 sg13_lv_nmos L=0.13U W=1U AS=0.145P AD=0.295P
+ PS=1.29U PD=2.59U
* device instance $3 r0 *1 0.63,2.56 pfet
X$3 Y__t1 A__t1 VDD__t0 VDD__t1 sg13_lv_pmos L=0.13U W=0.8U AS=0.236P AD=0.116P
+ PS=2.19U PD=1.09U
* device instance $4 r0 *1 1.05,2.56 pfet
X$4 VDD__t2 B__t1 Y__t2 VDD__t3 sg13_lv_pmos L=0.13U W=0.8U AS=0.116P AD=0.236P
+ PS=1.09U PD=2.19U
* device instance _2_t0 r0 *1 0,0
R_2_t0 \$2__t0 \$2 0.28875
* device instance _2_t1 r0 *1 0,0
R_2_t1 \$2__t1 \$2 0.28875
* device instance _2 r0 *1 0,0
C_2 \$2 vsubs 8.3876e-17
* device instance A_t0 r0 *1 0,0
RA_t0 A__t0 A 0.11345
* device instance A_t1 r0 *1 0,0
RA_t1 A__t1 A 0.11345
* device instance A r0 *1 0,0
CA A vsubs 4.0642e-17
* device instance B_t0 r0 *1 0,0
RB_t0 B__t0 B 0.11345
* device instance B_t1 r0 *1 0,0
RB_t1 B__t1 B 0.11345
* device instance B r0 *1 0,0
CB B vsubs 4.0642e-17
* device instance VDD_t0 r0 *1 0,0
RVDD_t0 VDD__t0 VDD 0.6222
* device instance VDD_t1 r0 *1 0,0
RVDD_t1 VDD__t1 VDD 0.6222
* device instance VDD_t2 r0 *1 0,0
RVDD_t2 VDD__t2 VDD 0.6222
* device instance VDD_t3 r0 *1 0,0
RVDD_t3 VDD__t3 VDD 0.6222
* device instance VDD r0 *1 0,0
CVDD VDD vsubs 3.19543e-16
* device instance VSS_t0 r0 *1 0,0
RVSS_t0 VSS__t0 VSS 1.00375
* device instance VSS_t1 r0 *1 0,0
RVSS_t1 VSS__t1 VSS 0.501875
* device instance VSS_t2 r0 *1 0,0
RVSS_t2 VSS__t2 VSS 0.501875
* device instance VSS r0 *1 0,0
CVSS VSS vsubs 2.60203e-16
* device instance Y_t0 r0 *1 0,0
RY_t0 Y__t0 Y 0.914385983771
* device instance Y_t1 r0 *1 0,0
RY_t1 Y__t1 Y 0.467870646427
* device instance Y_t2 r0 *1 0,0
RY_t2 Y__t2 Y 0.508343369802
* device instance Y r0 *1 0,0
CY Y vsubs 2.45791e-16
* device instance vsubs_dctie r0 *1 0,0
Rvsubs_dctie vsubs 0 1e+12
.ENDS sg13g2_nand2_1
