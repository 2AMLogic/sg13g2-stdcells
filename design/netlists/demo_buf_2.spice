* demo_buf_2 -- generated by design/gen_netlists.py from example_config.json; do not edit.
* family buf, drive 2, L=100n, supply 1.00 V.
* X = A
.subckt demo_buf_2 A X VDD VSS
XMN0 X_i A VSS VSS demo_nmos w=500n l=100n ng=1 m=1
XMP0 X_i A VDD VDD demo_pmos w=800n l=100n ng=1 m=1
XMN1 X X_i VSS VSS demo_nmos w=1000n l=100n ng=1 m=1
XMP1 X X_i VDD VDD demo_pmos w=1600n l=100n ng=2 m=1
.ends demo_buf_2
