* demo_a21oi_1 -- generated by design/gen_netlists.py from example_config.json; do not edit.
* family a21oi, drive 1, L=100n, supply 1.00 V.
* Y = !((A1*A2)+B1)
.subckt demo_a21oi_1 A1 A2 B1 Y VDD VSS
XMN0 Y A1 n1 VSS demo_nmos w=1000n l=100n ng=1 m=1
XMN1 n1 A2 VSS VSS demo_nmos w=1000n l=100n ng=1 m=1
XMN2 Y B1 VSS VSS demo_nmos w=500n l=100n ng=1 m=1
XMP0 Y A1 n2 VDD demo_pmos w=1600n l=100n ng=2 m=1
XMP1 Y A2 n2 VDD demo_pmos w=1600n l=100n ng=2 m=1
XMP2 n2 B1 VDD VDD demo_pmos w=1600n l=100n ng=2 m=1
.ends demo_a21oi_1
