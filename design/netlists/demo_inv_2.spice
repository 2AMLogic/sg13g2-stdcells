* demo_inv_2 -- generated by design/gen_netlists.py from example_config.json; do not edit.
* family inv, drive 2, L=100n, supply 1.00 V.
* Y = !A
.subckt demo_inv_2 A Y VDD VSS
XMN0 Y A VSS VSS demo_nmos w=1000n l=100n ng=1 m=1
XMP0 Y A VDD VDD demo_pmos w=1600n l=100n ng=2 m=1
.ends demo_inv_2
