* demo_a21o_2 -- generated by design/gen_netlists.py from example_config.json; do not edit.
* family a21o, drive 2, L=100n, supply 1.00 V.
* X = ((A1*A2)+B1)
.subckt demo_a21o_2 A1 A2 B1 X VDD VSS
XMN0 X_i A1 n1 VSS demo_nmos w=1000n l=100n ng=1 m=1
XMN1 n1 A2 VSS VSS demo_nmos w=1000n l=100n ng=1 m=1
XMN2 X_i B1 VSS VSS demo_nmos w=500n l=100n ng=1 m=1
XMP0 X_i A1 n2 VDD demo_pmos w=1600n l=100n ng=2 m=1
XMP1 X_i A2 n2 VDD demo_pmos w=1600n l=100n ng=2 m=1
XMP2 n2 B1 VDD VDD demo_pmos w=1600n l=100n ng=2 m=1
XMN3 X X_i VSS VSS demo_nmos w=1000n l=100n ng=1 m=1
XMP3 X X_i VDD VDD demo_pmos w=1600n l=100n ng=2 m=1
.ends demo_a21o_2
