* demo_nand4_1 -- generated by design/gen_netlists.py from example_config.json; do not edit.
* family nand4, drive 1, L=100n, supply 1.00 V.
* Y = !(A*B*C*D)
.subckt demo_nand4_1 A B C D Y VDD VSS
XMN0 Y A n1 VSS demo_nmos w=2000n l=100n ng=2 m=1
XMN1 n1 B n2 VSS demo_nmos w=2000n l=100n ng=2 m=1
XMN2 n2 C n3 VSS demo_nmos w=2000n l=100n ng=2 m=1
XMN3 n3 D VSS VSS demo_nmos w=2000n l=100n ng=2 m=1
XMP0 Y A VDD VDD demo_pmos w=800n l=100n ng=1 m=1
XMP1 Y B VDD VDD demo_pmos w=800n l=100n ng=1 m=1
XMP2 Y C VDD VDD demo_pmos w=800n l=100n ng=1 m=1
XMP3 Y D VDD VDD demo_pmos w=800n l=100n ng=1 m=1
.ends demo_nand4_1
