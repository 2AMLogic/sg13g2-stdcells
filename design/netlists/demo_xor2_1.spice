* demo_xor2_1 -- generated by design/gen_netlists.py from example_config.json; do not edit.
* family xor2, drive 1, L=100n, supply 1.00 V.
* X = (A^B)
.subckt demo_xor2_1 A B X VDD VSS
XMN0 X_i A n1 VSS demo_nmos w=1000n l=100n ng=1 m=1
XMN1 B_b B VSS VSS demo_nmos w=500n l=100n ng=1 m=1
XMP0 B_b B VDD VDD demo_pmos w=800n l=100n ng=1 m=1
XMN2 n1 B_b VSS VSS demo_nmos w=1000n l=100n ng=1 m=1
XMN3 A_b A VSS VSS demo_nmos w=500n l=100n ng=1 m=1
XMP1 A_b A VDD VDD demo_pmos w=800n l=100n ng=1 m=1
XMN4 X_i A_b n2 VSS demo_nmos w=1000n l=100n ng=1 m=1
XMN5 n2 B VSS VSS demo_nmos w=1000n l=100n ng=1 m=1
XMP2 X_i A n3 VDD demo_pmos w=1600n l=100n ng=2 m=1
XMP3 X_i B_b n3 VDD demo_pmos w=1600n l=100n ng=2 m=1
XMP4 n3 A_b VDD VDD demo_pmos w=1600n l=100n ng=2 m=1
XMP5 n3 B VDD VDD demo_pmos w=1600n l=100n ng=2 m=1
XMN6 X X_i VSS VSS demo_nmos w=500n l=100n ng=1 m=1
XMP6 X X_i VDD VDD demo_pmos w=800n l=100n ng=1 m=1
.ends demo_xor2_1
