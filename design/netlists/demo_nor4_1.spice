* demo_nor4_1 -- generated by design/gen_netlists.py from example_config.json; do not edit.
* family nor4, drive 1, L=100n, supply 1.00 V.
* Y = !(A+B+C+D)
.subckt demo_nor4_1 A B C D Y VDD VSS
XMN0 Y A VSS VSS demo_nmos w=500n l=100n ng=1 m=1
XMN1 Y B VSS VSS demo_nmos w=500n l=100n ng=1 m=1
XMN2 Y C VSS VSS demo_nmos w=500n l=100n ng=1 m=1
XMN3 Y D VSS VSS demo_nmos w=500n l=100n ng=1 m=1
XMP0 Y A n1 VDD demo_pmos w=3200n l=100n ng=4 m=1
XMP1 n1 B n2 VDD demo_pmos w=3200n l=100n ng=4 m=1
XMP2 n2 C n3 VDD demo_pmos w=3200n l=100n ng=4 m=1
XMP3 n3 D VDD VDD demo_pmos w=3200n l=100n ng=4 m=1
.ends demo_nor4_1
