* demo_mux2_1 -- generated by design/gen_netlists.py from example_config.json; do not edit.
* family mux2, drive 1, L=100n, supply 1.00 V.
* X = ((A0*!S)+(A1*S))
.subckt demo_mux2_1 A0 A1 S X VDD VSS
XMN0 X_i A0 n1 VSS demo_nmos w=1000n l=100n ng=1 m=1
XMN1 S_b S VSS VSS demo_nmos w=500n l=100n ng=1 m=1
XMP0 S_b S VDD VDD demo_pmos w=800n l=100n ng=1 m=1
XMN2 n1 S_b VSS VSS demo_nmos w=1000n l=100n ng=1 m=1
XMN3 X_i A1 n2 VSS demo_nmos w=1000n l=100n ng=1 m=1
XMN4 n2 S VSS VSS demo_nmos w=1000n l=100n ng=1 m=1
XMP1 X_i A0 n3 VDD demo_pmos w=1600n l=100n ng=2 m=1
XMP2 X_i S_b n3 VDD demo_pmos w=1600n l=100n ng=2 m=1
XMP3 n3 A1 VDD VDD demo_pmos w=1600n l=100n ng=2 m=1
XMP4 n3 S VDD VDD demo_pmos w=1600n l=100n ng=2 m=1
XMN5 X X_i VSS VSS demo_nmos w=500n l=100n ng=1 m=1
XMP5 X X_i VDD VDD demo_pmos w=800n l=100n ng=1 m=1
.ends demo_mux2_1
