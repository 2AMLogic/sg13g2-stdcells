* demo_nand2_1 -- generated by design/gen_netlists.py from example_config.json; do not edit.
* family nand2, drive 1, L=100n, supply 1.00 V.
* Y = !(A*B)
.subckt demo_nand2_1 A B Y VDD VSS
XMN0 Y A n1 VSS demo_nmos w=1000n l=100n ng=1 m=1
XMN1 n1 B VSS VSS demo_nmos w=1000n l=100n ng=1 m=1
XMP0 Y A VDD VDD demo_pmos w=800n l=100n ng=1 m=1
XMP1 Y B VDD VDD demo_pmos w=800n l=100n ng=1 m=1
.ends demo_nand2_1
