* demo_and2_1 -- generated by design/gen_netlists.py from example_config.json; do not edit.
* family and2, drive 1, L=100n, supply 1.00 V.
* X = (A*B)
.subckt demo_and2_1 A B X VDD VSS
XMN0 X_i A n1 VSS demo_nmos w=1000n l=100n ng=1 m=1
XMN1 n1 B VSS VSS demo_nmos w=1000n l=100n ng=1 m=1
XMP0 X_i A VDD VDD demo_pmos w=800n l=100n ng=1 m=1
XMP1 X_i B VDD VDD demo_pmos w=800n l=100n ng=1 m=1
XMN2 X X_i VSS VSS demo_nmos w=500n l=100n ng=1 m=1
XMP2 X X_i VDD VDD demo_pmos w=800n l=100n ng=1 m=1
.ends demo_and2_1
